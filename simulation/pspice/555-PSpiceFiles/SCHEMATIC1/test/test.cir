** Profile: "SCHEMATIC1-test"  [ d:\projects\555\555-pspicefiles\schematic1\test.sim ]

** Creating circuit file "test.cir"
** WARNING: THIS AUTOMATICALLY GENERATED FILE MAY BE OVERWRITTEN BY SUBSEQUENT SIMULATIONS

*Libraries:
* Profile Libraries :
* Local Libraries :
* From [PSPICE NETLIST] section of C:\cds_spb_home\cdssetup\OrCAD_PSpiceTIPSpice_Install\23.1.0\PSpice.ini file:
.lib "nom_pspti.lib"
.lib "nom.lib"

*Analysis directives:
.TRAN  0 5ms 0 5us
.OPTIONS ADVCONV
.OPTIONS FILEMODELSEARCH
.OPTIONS ITL1= 200
.OPTIONS ITL4= 40
.OPTIONS RELTOL= 0.01
.OPTIONS PTRANABSTOL= 1e-5
.OPTIONS PTRANVNTOL= 1e-4
.PROBE64 V(alias(*)) I(alias(*)) W(alias(*)) D(alias(*)) NOISE(alias(*))
.INC "..\SCHEMATIC1.net"

.END
